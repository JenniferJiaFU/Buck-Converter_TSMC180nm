ADE simulation setup
Test jf_ELEC5520_proj1_BuckConverter_tb_1: jf_ELEC5520/proj1_BuckConverter_tb/schematic, simulator spectre
  Models: /afs/ee.ust.hk/sun4x_56/usr/eelocal/tsmc_icdc/tsmc180/tsmc180_MS_RF_G/PDK/Cadence_OA/t018cmsp018k3_1_0a/1P6M_4X1U_40KUTM_2fF/tsmc18/../models/spectre/cr018gpii_v1d0.scs[tt_rfres_sa, tt_rfmvar, tt_rtmom, tt_disres, tt, tt_rfesd, tt_mim, tt_fmom, tt_rfres_rpo, tt_m, tt_rfmim, tt_res, tt_bip, tt_bip3, tt_dio3, tt_3v, tt_na, tt_dio, tt_dio_m, tt_rfind, tt_dio_3m, tt_bbmvar, tt_rfres_hri, tt_3vna, tt_dio_dnw, tt_3m, tt_rfjvar, tt_rfmos, tt_rfsbd, tt_rfmvar_33, tt_rfmos33, tt_rffmom, stat_noise]
  Variables: Duty = 0.565; Rload = 3.6
  Temperature: 27
  Analysis tran: stop=200u errpreset=liberal
  Output Vo_ave = average(clip(v("/Vo" ?result "tran") 0.00018 0.0002))
  Output Ivy = ymin(clip(i("/L0/PLUS" ?result "tran") 0.00018 0.0002))
  Output Ipk = ymax(clip(i("/L0/PLUS" ?result "tran") 0.00018 0.0002))
  Output Vo_ripple = (ymax(clip(v("/Vo" ?result "tran") 0.00018 0.0002)) - ymin(clip(v("/Vo" ?result "tran") 0.00018 0.0002)))
  Output Pg = average(clip((VT("/AVDD") * IT("/M10/S")) 0.00018 0.0002))
  Output Po = average(clip((VT("/Vo") * IT("/R0/PLUS")) 0.00018 0.0002))
  Output ita=Po/Pg = (average(clip((VT("/Vo") * IT("/R0/PLUS")) 0.00018 0.0002)) / average(clip((VT("/AVDD") * IT("/M10/S")) 0.00018 0.0002)))
  Signals: /AVDD, /Vx, /Vo, /CLKS1, /CLKS2, /VcD1, /VcD2, /L0/PLUS (terminal), /M0/D (terminal), /M10/S (terminal), /R0/PLUS (terminal)
Test jf_ELEC5520_proj1_BuckConverter_tb_1_1: jf_ELEC5520/proj1_BuckConverter_tb/schematic, simulator spectre
  Models: /afs/ee.ust.hk/sun4x_56/usr/eelocal/tsmc_icdc/tsmc180/tsmc180_MS_RF_G/PDK/Cadence_OA/t018cmsp018k3_1_0a/1P6M_4X1U_40KUTM_2fF/tsmc18/../models/spectre/cr018gpii_v1d0.scs[tt_rfres_sa, tt_rfmvar, tt_rtmom, tt_disres, tt, tt_rfesd, tt_mim, tt_fmom, tt_rfres_rpo, tt_m, tt_rfmim, tt_res, tt_bip, tt_bip3, tt_dio3, tt_3v, tt_na, tt_dio, tt_dio_m, tt_rfind, tt_dio_3m, tt_bbmvar, tt_rfres_hri, tt_3vna, tt_dio_dnw, tt_3m, tt_rfjvar, tt_rfmos, tt_rfsbd, tt_rfmvar_33, tt_rfmos33, tt_rffmom, stat_noise]
  Variables: Duty = 0.38; Rload = 18
  Temperature: 27
  Analysis tran: stop=400u errpreset=conservative
  Output Vo_ave = average(clip(v("/Vo" ?result "tran") 0.00038 0.0004))
  Output Ivy = ymin(clip(i("/L0/PLUS" ?result "tran") 0.00038 0.0004))
  Output Ipk = ymax(clip(i("/L0/PLUS" ?result "tran") 0.00038 0.0004))
  Output Vo_ripple = (ymax(clip(v("/Vo" ?result "tran") 0.00038 0.0004)) - ymin(clip(v("/Vo" ?result "tran") 0.00038 0.0004)))
  Output Pg = average(clip((VT("/AVDD") * IT("/M10/S")) 0.00038 0.0004))
  Output Po = average(clip((VT("/Vo") * IT("/R0/PLUS")) 0.00038 0.0004))
  Output ita=Po/Pg = (average(clip((VT("/Vo") * IT("/R0/PLUS")) 0.00038 0.0004)) / average(clip((VT("/AVDD") * IT("/M10/S")) 0.00038 0.0004)))
  Output average(clip(IT("/R0/PLUS") 0.00038 0.0004))
  Signals: /AVDD, /Vx, /Vo, /CLKS1, /CLKS2, /VcD1, /VcD2, /L0/PLUS (terminal), /M0/D (terminal), /M10/S (terminal), /R0/PLUS (terminal)
Run mode: Single Run, Sweeps and Corners
Specs:
  jf_ELEC5520_proj1_BuckConverter_tb_1 / Vo_ave: range 1.782 to 1.818
  jf_ELEC5520_proj1_BuckConverter_tb_1 / Ivy: range 198m to 202m
  jf_ELEC5520_proj1_BuckConverter_tb_1 / Ipk: range 792m to 808m
  jf_ELEC5520_proj1_BuckConverter_tb_1 / Vo_ripple: < 50m
  jf_ELEC5520_proj1_BuckConverter_tb_1 / ita=Po/Pg: > 0.85
  jf_ELEC5520_proj1_BuckConverter_tb_1_1 / Vo_ripple: < 50m
  jf_ELEC5520_proj1_BuckConverter_tb_1_1 / ita=Po/Pg: > 0.85
  jf_ELEC5520_proj1_BuckConverter_tb_1_1 / Vo_ave: range 1.782 to 1.818
Disabled tests: jf_ELEC5520_proj1_BuckConverter_tb_1
