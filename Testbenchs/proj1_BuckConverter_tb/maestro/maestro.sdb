ADE simulation setup
Run mode: Single Run, Sweeps and Corners
Tests:
  jf_ELEC5520_proj1_BuckConverter_tb_1 (off): jf_ELEC5520/proj1_BuckConverter_tb/schematic, simulator spectre
    Variables: Rload = 3.6; Duty = 0.565
    Outputs: Pg; average((3.3 * clip(IT("/M10/S") 9e-05 0.0001))); Po; ita=Po/Pg; Vo_ave; Ivy; Ipk; Vo_ripple
  jf_ELEC5520_proj1_BuckConverter_tb_1_1: jf_ELEC5520/proj1_BuckConverter_tb/schematic, simulator spectre
    Variables: Rload = 18; Duty = 0.38
    Outputs: Pg; average((3.3 * clip(IT("/M10/S") 9e-05 0.0001))); Po; ita=Po/Pg; Vo_ave; Ivy; Ipk; Vo_ripple
Specs:
  jf_ELEC5520_proj1_BuckConverter_tb_1 / Vo_ave: range 1.782 to 1.818
  jf_ELEC5520_proj1_BuckConverter_tb_1 / Ivy: range 198m to 202m
  jf_ELEC5520_proj1_BuckConverter_tb_1 / Ipk: range 792m to 808m
  jf_ELEC5520_proj1_BuckConverter_tb_1 / Vo_ripple: < 50m
  jf_ELEC5520_proj1_BuckConverter_tb_1 / ita=Po/Pg: > 0.85
  jf_ELEC5520_proj1_BuckConverter_tb_1_1 / Vo_ripple: < 50m
  jf_ELEC5520_proj1_BuckConverter_tb_1_1 / ita=Po/Pg: > 0.85
  jf_ELEC5520_proj1_BuckConverter_tb_1_1 / Vo_ave: range 1.782 to 1.818
